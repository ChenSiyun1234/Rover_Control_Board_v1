* Source: rev_e9beafa/single_board.kicad_sch; commit e9beafa
* kicad-cli sch export netlist --format kicadsexpr single_board.kicad_sch
* kicad-cli sch export netlist --format spice single_board.kicad_sch
* Generated by python -m board.extract_fsr; values below are KiCad SPICE values.
* Sensor connector: J30.1 sensor_a; J30.2 sensor_b
.subckt fsr_front sensor_a sensor_b adc v3v3 gnd gate
* C8: schematic value 100nF
C8 adc gnd 100n
* Q4: schematic value AO3401A
* https://www.aosmd.com/sites/default/files/res/datasheets/AO3401A.pdf
* Electrical Characteristics, STATIC PARAMETERS, p.2: Rds(on) max 85mOhm
* at Vgs=-2.5V; Vgs(th) typical -0.9V. Assumed ideal switch; Roff=1e12.
SQ4 v3v3 sensor_b v3v3 gate Q4_AO3401A
.model Q4_AO3401A SW(Ron=0.085 Roff=1e12 Vt=0.9 Vh=0)
* R28: schematic value 10k
R28 gate v3v3 10k
* R29: schematic value 1M
R29 sensor_a gnd 1Meg
* R36: schematic value 10k
R36 adc sensor_a 10k
.ends fsr_front
