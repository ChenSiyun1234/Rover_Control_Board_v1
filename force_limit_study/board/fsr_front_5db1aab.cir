* Source: rev_5db1aab/single_board.kicad_sch; commit 5db1aab
* kicad-cli sch export netlist --format kicadsexpr single_board.kicad_sch
* kicad-cli sch export netlist --format spice single_board.kicad_sch
* Generated by python -m board.extract_fsr; values below are KiCad SPICE values.
* Sensor connector: J27.1 sensor_a; J27.2 sensor_b
.subckt fsr_front sensor_a sensor_b adc v3v3 gnd
Vport1 sensor_a adc 0
Vport2 sensor_b v3v3 0
* C32: schematic value 10nF
C32 adc gnd 10n
* R26: schematic value 1M
R26 adc gnd 1Meg
.ends fsr_front
